* ==================================================================
* PCIe Gen2 equalizer (CTLE + 1-tap DFE summer) -- auto-sized by RL (CEM)
* closed-loop eye, DFE loop CLOSED
* Requested (W/L in um, R in ohm, C in F, I in A):
*   W=24.27  L=0.2  RL=782.875  Rs=2208.7
*   Cs=2.5779e-13  Itail=0.000635023  Wtail=97.93
*   Rsum=1732.91  Wg1=42.94  Ig1=0.000407005
*   tap_pct=1.379%  -> Wgf=0.5922 Igf=5.61272e-06
*   CL=4e-14  Vcm=1.1
* Realised geometry:
*   RL -> l=2.008 m=1 (782.875 ohm)
*   Rs -> l=8.39 m=1 (2208.7 ohm)
*   Cs -> 11.16 x 11.16 um (2.5779e-13 F)
*   Rsum -> l=6.261 m=1 (1732.91 ohm)
*   Iref=0.000158756  Wref=24.48
*   Gm1 tail W=62.77   GmF tail W=0.8656
*   nominal tap weight gmF/gm1 = 0.01379
* corner: tt_1.800V_27C
* ==================================================================
.lib "/home/kanishk/.volare/volare/sky130/versions/c6d73a35f524070e85faff4a6a9eef49553ebc2b/sky130A/libs.tech/ngspice/sky130.lib.spice" tt
.temp 27

Vdd vdd 0 DC 1.8
Vinp vinp 0 PWL(0 1.15 1.85e-10 1.15 2.15e-10 1.05 3.85e-10 1.05 4.15e-10 1.15 9.85e-10 1.15 1.015e-09 1.05 1.385e-09 1.05 1.415e-09 1.15 1.785e-09 1.15 1.815e-09 1.05 2.185e-09 1.05 2.215e-09 1.15 2.385e-09 1.15 2.415e-09 1.05 2.585e-09 1.05 2.615e-09 1.15 2.785e-09 1.15 2.815e-09 1.05 2.985e-09 1.05 3.015e-09 1.15 3.185e-09 1.15 3.215e-09 1.05 3.385e-09 1.05 3.415e-09 1.15 4.785e-09 1.15 4.815e-09 1.05 5.985e-09 1.05 6.015e-09 1.15 6.185e-09 1.15 6.215e-09 1.05 7.185e-09 1.05 7.215e-09 1.15 7.585e-09 1.15 7.615e-09 1.05 8.385e-09 1.05 8.415e-09 1.15 8.585e-09 1.15 8.615e-09 1.05 8.785e-09 1.05 8.815e-09 1.15 8.985e-09 1.15 9.015e-09 1.05 9.585e-09 1.05 9.615e-09 1.15 1.0385e-08 1.15 1.0415e-08 1.05 1.0785e-08 1.05 1.0815e-08 1.15 1.0985e-08 1.15 1.1015e-08 1.05 1.1585e-08 1.05 1.1615e-08 1.15 1.1785e-08 1.15 1.1815e-08 1.05 1.1985e-08 1.05 1.2015e-08 1.15 1.2385e-08 1.15 1.2415e-08 1.05 1.2785e-08 1.05 1.2815e-08 1.15 1.3385e-08 1.15 1.3415e-08 1.05 1.3585e-08 1.05 1.3615e-08 1.15 1.3785e-08 1.15 1.3815e-08 1.05 1.3985e-08 1.05 1.4015e-08 1.15 1.4185e-08 1.15 1.4215e-08 1.05 1.4585e-08 1.05 1.4615e-08 1.15 1.5585e-08 1.15 1.5615e-08 1.05 1.5785e-08 1.05 1.5815e-08 1.15 1.5985e-08 1.15 1.6015e-08 1.05 1.6785e-08 1.05 1.6815e-08 1.15 1.7385e-08 1.15 1.7415e-08 1.05 1.7985e-08 1.05 1.8015e-08 1.15 1.8185e-08 1.15 1.8215e-08 1.05 1.8585e-08 1.05 1.8615e-08 1.15 1.8785e-08 1.15 1.8815e-08 1.05 1.9185e-08 1.05 1.9215e-08 1.15 1.9585e-08 1.15 1.9615e-08 1.05 1.9785e-08 1.05 1.9815e-08 1.15 2.0185e-08 1.15 2.0215e-08 1.05 2.0385e-08 1.05 2.0415e-08 1.15 2.0585e-08 1.15 2.0615e-08 1.05 2.0785e-08 1.05 2.0815e-08 1.15 2.1185e-08 1.15 2.1215e-08 1.05 2.1385e-08 1.05 2.1415e-08 1.15 2.2185e-08 1.15 2.2215e-08 1.05 2.2385e-08 1.05 2.2415e-08 1.15 2.2785e-08 1.15 2.2815e-08 1.05 2.3385e-08 1.05 2.3415e-08 1.15 2.3785e-08 1.15 2.3815e-08 1.05 2.3985e-08 1.05 2.4015e-08 1.15 2.4185e-08 1.15 2.4215e-08 1.05 2.4585e-08 1.05 2.4615e-08 1.15 2.4785e-08 1.15 2.4815e-08 1.05 2.4985e-08 1.05 2.5015e-08 1.15 2.5585e-08 1.15 2.5615e-08 1.05 2.5785e-08 1.05 2.5815e-08 1.15 2.6385e-08 1.15 2.6415e-08 1.05 2.6785e-08 1.05 2.6815e-08 1.15 2.7185e-08 1.15 2.7215e-08 1.05 2.7585e-08 1.05 2.7615e-08 1.15 2.7785e-08 1.15 2.7815e-08 1.05 2.7985e-08 1.05 2.8015e-08 1.15 2.8185e-08 1.15 2.8215e-08 1.05 2.8385e-08 1.05 2.8415e-08 1.15 2.8585e-08 1.15 2.8615e-08 1.05 2.8785e-08 1.05 2.8815e-08 1.15 3.0185e-08 1.15 3.0215e-08 1.05 3.1385e-08 1.05 3.1415e-08 1.15 3.1585e-08 1.15 3.1615e-08 1.05 3.2585e-08 1.05 3.2615e-08 1.15 3.2985e-08 1.15 3.3015e-08 1.05 3.3785e-08 1.05 3.3815e-08 1.15 3.3985e-08 1.15 3.4015e-08 1.05 3.4185e-08 1.05 3.4215e-08 1.15 3.4385e-08 1.15 3.4415e-08 1.05 3.4985e-08 1.05 3.5015e-08 1.15 3.5785e-08 1.15 3.5815e-08 1.05 3.6185e-08 1.05 3.6215e-08 1.15 3.6385e-08 1.15 3.6415e-08 1.05 3.6985e-08 1.05 3.7015e-08 1.15 3.7185e-08 1.15 3.7215e-08 1.05 3.7385e-08 1.05 3.7415e-08 1.15 3.7785e-08 1.15 3.7815e-08 1.05 3.8185e-08 1.05 3.8215e-08 1.15 3.8785e-08 1.15 3.8815e-08 1.05 3.8985e-08 1.05 3.9015e-08 1.15 3.9185e-08 1.15 3.9215e-08 1.05 3.9385e-08 1.05 3.9415e-08 1.15 3.9585e-08 1.15 3.9615e-08 1.05 4e-08 1.05)
Vinn vinn 0 PWL(0 1.05 1.85e-10 1.05 2.15e-10 1.15 3.85e-10 1.15 4.15e-10 1.05 9.85e-10 1.05 1.015e-09 1.15 1.385e-09 1.15 1.415e-09 1.05 1.785e-09 1.05 1.815e-09 1.15 2.185e-09 1.15 2.215e-09 1.05 2.385e-09 1.05 2.415e-09 1.15 2.585e-09 1.15 2.615e-09 1.05 2.785e-09 1.05 2.815e-09 1.15 2.985e-09 1.15 3.015e-09 1.05 3.185e-09 1.05 3.215e-09 1.15 3.385e-09 1.15 3.415e-09 1.05 4.785e-09 1.05 4.815e-09 1.15 5.985e-09 1.15 6.015e-09 1.05 6.185e-09 1.05 6.215e-09 1.15 7.185e-09 1.15 7.215e-09 1.05 7.585e-09 1.05 7.615e-09 1.15 8.385e-09 1.15 8.415e-09 1.05 8.585e-09 1.05 8.615e-09 1.15 8.785e-09 1.15 8.815e-09 1.05 8.985e-09 1.05 9.015e-09 1.15 9.585e-09 1.15 9.615e-09 1.05 1.0385e-08 1.05 1.0415e-08 1.15 1.0785e-08 1.15 1.0815e-08 1.05 1.0985e-08 1.05 1.1015e-08 1.15 1.1585e-08 1.15 1.1615e-08 1.05 1.1785e-08 1.05 1.1815e-08 1.15 1.1985e-08 1.15 1.2015e-08 1.05 1.2385e-08 1.05 1.2415e-08 1.15 1.2785e-08 1.15 1.2815e-08 1.05 1.3385e-08 1.05 1.3415e-08 1.15 1.3585e-08 1.15 1.3615e-08 1.05 1.3785e-08 1.05 1.3815e-08 1.15 1.3985e-08 1.15 1.4015e-08 1.05 1.4185e-08 1.05 1.4215e-08 1.15 1.4585e-08 1.15 1.4615e-08 1.05 1.5585e-08 1.05 1.5615e-08 1.15 1.5785e-08 1.15 1.5815e-08 1.05 1.5985e-08 1.05 1.6015e-08 1.15 1.6785e-08 1.15 1.6815e-08 1.05 1.7385e-08 1.05 1.7415e-08 1.15 1.7985e-08 1.15 1.8015e-08 1.05 1.8185e-08 1.05 1.8215e-08 1.15 1.8585e-08 1.15 1.8615e-08 1.05 1.8785e-08 1.05 1.8815e-08 1.15 1.9185e-08 1.15 1.9215e-08 1.05 1.9585e-08 1.05 1.9615e-08 1.15 1.9785e-08 1.15 1.9815e-08 1.05 2.0185e-08 1.05 2.0215e-08 1.15 2.0385e-08 1.15 2.0415e-08 1.05 2.0585e-08 1.05 2.0615e-08 1.15 2.0785e-08 1.15 2.0815e-08 1.05 2.1185e-08 1.05 2.1215e-08 1.15 2.1385e-08 1.15 2.1415e-08 1.05 2.2185e-08 1.05 2.2215e-08 1.15 2.2385e-08 1.15 2.2415e-08 1.05 2.2785e-08 1.05 2.2815e-08 1.15 2.3385e-08 1.15 2.3415e-08 1.05 2.3785e-08 1.05 2.3815e-08 1.15 2.3985e-08 1.15 2.4015e-08 1.05 2.4185e-08 1.05 2.4215e-08 1.15 2.4585e-08 1.15 2.4615e-08 1.05 2.4785e-08 1.05 2.4815e-08 1.15 2.4985e-08 1.15 2.5015e-08 1.05 2.5585e-08 1.05 2.5615e-08 1.15 2.5785e-08 1.15 2.5815e-08 1.05 2.6385e-08 1.05 2.6415e-08 1.15 2.6785e-08 1.15 2.6815e-08 1.05 2.7185e-08 1.05 2.7215e-08 1.15 2.7585e-08 1.15 2.7615e-08 1.05 2.7785e-08 1.05 2.7815e-08 1.15 2.7985e-08 1.15 2.8015e-08 1.05 2.8185e-08 1.05 2.8215e-08 1.15 2.8385e-08 1.15 2.8415e-08 1.05 2.8585e-08 1.05 2.8615e-08 1.15 2.8785e-08 1.15 2.8815e-08 1.05 3.0185e-08 1.05 3.0215e-08 1.15 3.1385e-08 1.15 3.1415e-08 1.05 3.1585e-08 1.05 3.1615e-08 1.15 3.2585e-08 1.15 3.2615e-08 1.05 3.2985e-08 1.05 3.3015e-08 1.15 3.3785e-08 1.15 3.3815e-08 1.05 3.3985e-08 1.05 3.4015e-08 1.15 3.4185e-08 1.15 3.4215e-08 1.05 3.4385e-08 1.05 3.4415e-08 1.15 3.4985e-08 1.15 3.5015e-08 1.05 3.5785e-08 1.05 3.5815e-08 1.15 3.6185e-08 1.15 3.6215e-08 1.05 3.6385e-08 1.05 3.6415e-08 1.15 3.6985e-08 1.15 3.7015e-08 1.05 3.7185e-08 1.05 3.7215e-08 1.15 3.7385e-08 1.15 3.7415e-08 1.05 3.7785e-08 1.05 3.7815e-08 1.15 3.8185e-08 1.15 3.8215e-08 1.05 3.8785e-08 1.05 3.8815e-08 1.15 3.8985e-08 1.15 3.9015e-08 1.05 3.9185e-08 1.05 3.9215e-08 1.15 3.9385e-08 1.15 3.9415e-08 1.05 3.9585e-08 1.05 3.9615e-08 1.15 4e-08 1.15)
* --- DFE decision path (IDEAL, XSPICE) ---
* sampled at the SUMMING NODE, not the CTLE output
Bdiff vdiff 0 V=V(outp_dfe)-V(outn_dfe)
Vclk clk 0 DC 0 PULSE(0 1.8 1e-10 10p 10p 8e-11 2e-10)
adc_in  [vdiff] [ddata] adc_sl
adc_clk [clk]   [dclk]  adc_ck
* clocked comparator: decide on this edge
acomp ddata dclk NULL NULL d1 d1b dff_1tap
* 1 UI hold: captures what the comparator held BEFORE this edge
ahold d1 dclk NULL NULL q1 q1b dff_1tap
* inverted decision drives vfbp so the tap SUBTRACTS (see docstring)
adac_p [q1b] [vfbp] dac_fb
adac_n [q1]  [vfbn] dac_fb
.model adc_sl  adc_bridge(in_low=-0.001 in_high=0.001)
.model adc_ck  adc_bridge(in_low=0.7 in_high=1.1)
.model dac_fb  dac_bridge(out_low=0.8 out_high=1.4 out_undef=1.1 t_rise=15p t_fall=15p)
.model dff_1tap d_dff(clk_delay=20p rise_delay=15p fall_delay=15p)

* --- STAGE 1: CTLE, source-degenerated diff pair, real SKY130 devices ---
* input pair
X1 outn_ctle vinp sp 0 sky130_fd_pr__nfet_01v8_lvt L=0.2 W=24.27 nf=2 m=1
X2 outp_ctle vinn sn 0 sky130_fd_pr__nfet_01v8_lvt L=0.2 W=24.27 nf=2 m=1
* degeneration: real poly resistor + real MIM cap  (b = body tie to substrate)
XRs sp sn 0 sky130_fd_pr__res_high_po_1p41 w=1.41 l=8.39 m=1
XCs sp sn sky130_fd_pr__cap_mim_m3_1 w=11.16 l=11.16 mf=1
* loads
XRLp vdd outp_ctle 0 sky130_fd_pr__res_high_po_1p41 w=1.41 l=2.008 m=1
XRLn vdd outn_ctle 0 sky130_fd_pr__res_high_po_1p41 w=1.41 l=2.008 m=1
* CL stays ideal: it models the NEXT stage's input capacitance
CLp outp_ctle 0 4e-14
CLn outn_ctle 0 4e-14
* tail: 4:1 NMOS current mirror (Iref sourced from vdd).
* Xt1/Xt2 are the SAME unit device as Xref, replicated m=4 times --
* a mirror ratios by multiplicity, not by making one device wider.
Iref vdd vbias DC 0.000158756
Xref vbias vbias 0 0 sky130_fd_pr__nfet_01v8_lvt L=0.5 W=24.48 nf=2 m=1
Xt1  sp vbias 0 0 sky130_fd_pr__nfet_01v8_lvt L=0.5 W=24.48 nf=2 m=4
Xt2  sn vbias 0 0 sky130_fd_pr__nfet_01v8_lvt L=0.5 W=24.48 nf=2 m=4
* --- STAGE 2: DFE summing stage (Gm1 + GmF share one load pair) ---
* summing-node loads -- these ARE the summer
XRsp vdd outp_dfe 0 sky130_fd_pr__res_high_po_1p41 w=1.41 l=6.261 m=1
XRsn vdd outn_dfe 0 sky130_fd_pr__res_high_po_1p41 w=1.41 l=6.261 m=1
* Gm1: main signal path, gates driven by the CTLE output (drains crossed)
XG1p outn_dfe outp_ctle sgm1 0 sky130_fd_pr__nfet_01v8_lvt L=0.18 W=42.94 nf=4 m=1
XG1n outp_dfe outn_ctle sgm1 0 sky130_fd_pr__nfet_01v8_lvt L=0.18 W=42.94 nf=4 m=1
* GmF: feedback tap, gates driven by the held decision (same crossing as Gm1)
XGFp outn_dfe vfbp sgmf 0 sky130_fd_pr__nfet_01v8_lvt L=0.18 W=0.5922 nf=1 m=1
XGFn outp_dfe vfbn sgmf 0 sky130_fd_pr__nfet_01v8_lvt L=0.18 W=0.5922 nf=1 m=1
* separate tails, both mirrored off the same vbias as the CTLE.
* Names must not collide with the CTLE's Xt1/Xt2 even case-insensitively --
* ngspice folds case, so `XT1` IS `Xt1` and the deck dies with
* "device already exists, bail out".
XTsum1 sgm1 vbias 0 0 sky130_fd_pr__nfet_01v8_lvt L=0.5 W=62.77 nf=6 m=1
XTsumf sgmf vbias 0 0 sky130_fd_pr__nfet_01v8_lvt L=0.5 W=0.8656 nf=1 m=1

.control
tran 4e-12 4e-08 0 4e-12
wrdata eye.dat v(outp_dfe,outn_dfe) v(vfbp)
.endc
.end
